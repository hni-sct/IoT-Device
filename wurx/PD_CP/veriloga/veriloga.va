//
// PD_CP Module VerilogA Source Code
//
// Copyright (C) 2021, Saed Abughannam
// Heinz Nixdorf Institut/Paderborn University, Paderborn, Germany
//
// Permission is hereby granted, free of charge, to any person obtaining a
// copy of this file and associated documentation files,
// to deal the file without restriction, including without limitation
// the rights to use, copy, modify, merge, publish, distribute, sublicense,
// and/or sell copies of the file, and to permit persons to whom the
// file is furnished to do so, subject to the following conditions:
//
// The above copyright notice and this permission notice shall be included in
// all copies or substantial portions of the file.
//
// THE FILE IS PROVIDED "AS IS", WITHOUT WARRANTY OF ANY KIND, EXPRESS OR
// IMPLIED, INCLUDING BUT NOT LIMITED TO THE WARRANTIES OF MERCHANTABILITY,
// FITNESS FOR A PARTICULAR PURPOSE AND NONINFRINGEMENT. IN NO EVENT SHALL
// THE AUTHORS OR COPYRIGHT HOLDERS BE LIABLE FOR ANY CLAIM, DAMAGES OR OTHER
// LIABILITY, WHETHER IN AN ACTION OF CONTRACT, TORT OR OTHERWISE, ARISING
// FROM, OUT OF OR IN CONNECTION WITH THE FILE OR THE USE OR OTHER
// DEALINGS IN THE FILE.
//
// Version 1e, 3 August 2010
//
// Ken Kundert (ken@designers-guide.com)
//
// Downloaded from The Designer's Guide Community (www.designers-guide.org).
// Post any questions to www.designers-guide.org/Forum

`include "disciplines.vams"
`include "constants.vams"

module PD_CP(out, ref, fb);

output out; electrical out;		// current output
input ref; voltage ref;			// positive input (edge triggered)
input fb; voltage fb;			// inverting input (edge triggered)
real iout=100u;		// maximum output current
real vh=1.2;			// input voltage in high state
real vl=0;			// input voltage in low state
real vth=(vh+vl)/2;		// threshold voltage at input
integer dir=1 from [-1:1] exclude 0;
					// dir=1 for positive edge trigger
					// dir=-1 for negative edge trigger
parameter real tt=1n from (0:inf);	// transition time of output signal
parameter real td=0 from [0:inf);	// average delay from input to output
parameter real rclamp=100 from (0:inf);	// output clamp resistance
integer state;

analog begin
    // Implement phase detector
    @(cross(V(ref)-vth, dir))
	if (state > -1) state = state - 1;
    @(cross(V(fb)-vth, dir))
	if (state < 1) state = state + 1;

    // Implement charge pump
    I(out) <+ transition(iout*state, td, tt);

    // Implement output clamp (optional)
    if (V(out) > vh)
        I(out) <+ (V(out) - vh)/rclamp;
    else if (V(out) < vl)
        I(out) <+ (V(out) - vl)/rclamp;

    // Add gmin to output to avoid convergence issues (optional)
    I(out) <+ V(out)/1T;
    $bound_step(0.1/2M);
end
endmodule
