//
// BUFFER Module VerilogA Source Code
//
// Copyright (C) 2021, Saed Abughannam
// Heinz Nixdorf Institut/Paderborn University, Paderborn, Germany
//
// Permission is hereby granted, free of charge, to any person obtaining a
// copy of this file and associated documentation files,
// to deal the file without restriction, including without limitation
// the rights to use, copy, modify, merge, publish, distribute, sublicense,
// and/or sell copies of the file, and to permit persons to whom the
// file is furnished to do so, subject to the following conditions:
//
// The above copyright notice and this permission notice shall be included in
// all copies or substantial portions of the file.
//
// THE FILE IS PROVIDED "AS IS", WITHOUT WARRANTY OF ANY KIND, EXPRESS OR
// IMPLIED, INCLUDING BUT NOT LIMITED TO THE WARRANTIES OF MERCHANTABILITY,
// FITNESS FOR A PARTICULAR PURPOSE AND NONINFRINGEMENT. IN NO EVENT SHALL
// THE AUTHORS OR COPYRIGHT HOLDERS BE LIABLE FOR ANY CLAIM, DAMAGES OR OTHER
// LIABILITY, WHETHER IN AN ACTION OF CONTRACT, TORT OR OTHERWISE, ARISING
// FROM, OUT OF OR IN CONNECTION WITH THE FILE OR THE USE OR OTHER
// DEALINGS IN THE FILE.
//

`include "constants.vams"
`include "disciplines.vams"

module BUFFER(IN,EN,OUT);

electrical IN,OUT,EN;
input IN,EN;
output OUT;

real Buff;
real factor;

analog begin

    if (V(EN) >= 0.6)begin
    factor = 1;
    	@(timer(0, 1n) or initial_step) begin
	    Buff = factor * V(IN);
	    $discontinuity(0);
	end
    end

  V(OUT) <+ Buff;
end
endmodule
