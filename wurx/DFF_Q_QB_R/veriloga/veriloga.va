//
// DFF_Q_QB_R Module VerilogA Source Code
//
// Copyright (C) 2021, Saed Abughannam
// Heinz Nixdorf Institut/Paderborn University, Paderborn, Germany
//
// Permission is hereby granted, free of charge, to any person obtaining a
// copy of this file and associated documentation files,
// to deal the file without restriction, including without limitation
// the rights to use, copy, modify, merge, publish, distribute, sublicense,
// and/or sell copies of the file, and to permit persons to whom the
// file is furnished to do so, subject to the following conditions:
//
// The above copyright notice and this permission notice shall be included in
// all copies or substantial portions of the file.
//
// THE FILE IS PROVIDED "AS IS", WITHOUT WARRANTY OF ANY KIND, EXPRESS OR
// IMPLIED, INCLUDING BUT NOT LIMITED TO THE WARRANTIES OF MERCHANTABILITY,
// FITNESS FOR A PARTICULAR PURPOSE AND NONINFRINGEMENT. IN NO EVENT SHALL
// THE AUTHORS OR COPYRIGHT HOLDERS BE LIABLE FOR ANY CLAIM, DAMAGES OR OTHER
// LIABILITY, WHETHER IN AN ACTION OF CONTRACT, TORT OR OTHERWISE, ARISING
// FROM, OUT OF OR IN CONNECTION WITH THE FILE OR THE USE OR OTHER
// DEALINGS IN THE FILE.
//

`include "constants.vams"
`include "disciplines.vams"

module DFF_Q_QB_R(q, qb, clk, d, reset);

input clk, d, reset; output q, qb;
voltage clk, d, reset, q, qb;
parameter real v0=0;
parameter real v1=1.2 from (v0:inf);
parameter integer dir=1 from [-1:1] exclude 0;
parameter real td=0 from [0:inf);
parameter real tt=0 from [0:inf);
parameter integer init_state=0 from [0:1];
integer actNow, out, state;
real thresh;

analog begin
    thresh = (v0+v1)/2;
    actNow = 0;
    @(cross(V(clk) - thresh, dir) or cross(V(reset) - thresh, +1)) begin
	actNow = 1;
	state = (V(d) > thresh) && (V(reset) < thresh);
    end
    @(initial_step) begin
	actNow = 1;
	state = init_state;
    end
    out = idt(0, state, actNow);
    V(q) <+ transition(out ? v1 : v0, td, tt);
    V(qb) <+ v0 + v1 - V(q);
    $bound_step(0.1/2450e6);
end

endmodule
