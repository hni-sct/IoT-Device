//
// DFF_Q_R Module VerilogA Source Code
//
// Copyright (C) 2021, Saed Abughannam
// Heinz Nixdorf Institut/Paderborn University, Paderborn, Germany
//
// Permission is hereby granted, free of charge, to any person obtaining a
// copy of this file and associated documentation files,
// to deal the file without restriction, including without limitation
// the rights to use, copy, modify, merge, publish, distribute, sublicense,
// and/or sell copies of the file, and to permit persons to whom the
// file is furnished to do so, subject to the following conditions:
//
// The above copyright notice and this permission notice shall be included in
// all copies or substantial portions of the file.
//
// THE FILE IS PROVIDED "AS IS", WITHOUT WARRANTY OF ANY KIND, EXPRESS OR
// IMPLIED, INCLUDING BUT NOT LIMITED TO THE WARRANTIES OF MERCHANTABILITY,
// FITNESS FOR A PARTICULAR PURPOSE AND NONINFRINGEMENT. IN NO EVENT SHALL
// THE AUTHORS OR COPYRIGHT HOLDERS BE LIABLE FOR ANY CLAIM, DAMAGES OR OTHER
// LIABILITY, WHETHER IN AN ACTION OF CONTRACT, TORT OR OTHERWISE, ARISING
// FROM, OUT OF OR IN CONNECTION WITH THE FILE OR THE USE OR OTHER
// DEALINGS IN THE FILE.
//
// Ken Kundert
//
// Downloaded from The Designer's Guide (www.designers-guide.org).
// Post any questions to www.designers-guide.org/Forum

`include "constants.vams"
`include "disciplines.vams"

module DFF_Q_R(q, clk, d, s, r);

output q;
voltage q;	// Q output

input clk;
voltage clk;	// Clock input (edge triggered)

input d;
voltage d;	// D input

input s;
voltage s;	// Set input (immediately forces Q output high) (active high)

input r;
voltage r;	// Reset input (immediately forces Q output low) (active high)

real td = 0 ;	// delay from clock to q
real tt = 0 ;	// transition time of output signals
real vh = 1.2;	// output voltage in high state
real vl = 0;		// output voltage in low state
real vth = (vh + vl)/2;	// threshold voltage at inputs

integer dir = +1;
			// if dir=+1, rising clock edge triggers flip flop
			// if dir=-1, falling clock edge triggers flip flop

real out, outb;

analog begin
    @(initial_step) begin
	out = vl;
	outb = vh;
    end
    @(cross(V(clk) - vth, dir)) begin
	if (V(d) > vth) begin
	    out = vh;
	    outb = vl;
	end else begin
	    out = vl;
	    outb = vh;
	end
    end
    if (V(s) > vth) begin
	out = vh;
	outb = vl;
    end
    if (V(r) > vth) begin
	out = vl;
	outb = vh;
    end
    V(q) <+ transition( out, td, tt );
end
endmodule
