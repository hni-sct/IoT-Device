ADE simulation setup
Run mode: Single Run, Sweeps and Corners
Tests:
  SAFE4I_WuRx_VerilogA_1: SAFE4I/WuRx_VerilogA/schematic_deliverable, simulator spectre
