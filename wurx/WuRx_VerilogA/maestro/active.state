ADE simulation setup
Test SAFE4I_WuRx_VerilogA_1: SAFE4I/WuRx_VerilogA/schematic_deliverable, simulator spectre
  Temperature: 27
  Analysis tran: stop=100u
  Signals: /PPM, /WakeUp
Run mode: Single Run, Sweeps and Corners
