//
// DIODE Module VerilogA Source Code
//
// Copyright (C) 2021, Saed Abughannam
// Heinz Nixdorf Institut/Paderborn University, Paderborn, Germany
//
// Permission is hereby granted, free of charge, to any person obtaining a
// copy of this file and associated documentation files,
// to deal the file without restriction, including without limitation
// the rights to use, copy, modify, merge, publish, distribute, sublicense,
// and/or sell copies of the file, and to permit persons to whom the
// file is furnished to do so, subject to the following conditions:
//
// The above copyright notice and this permission notice shall be included in
// all copies or substantial portions of the file.
//
// THE FILE IS PROVIDED "AS IS", WITHOUT WARRANTY OF ANY KIND, EXPRESS OR
// IMPLIED, INCLUDING BUT NOT LIMITED TO THE WARRANTIES OF MERCHANTABILITY,
// FITNESS FOR A PARTICULAR PURPOSE AND NONINFRINGEMENT. IN NO EVENT SHALL
// THE AUTHORS OR COPYRIGHT HOLDERS BE LIABLE FOR ANY CLAIM, DAMAGES OR OTHER
// LIABILITY, WHETHER IN AN ACTION OF CONTRACT, TORT OR OTHERWISE, ARISING
// FROM, OUT OF OR IN CONNECTION WITH THE FILE OR THE USE OR OTHER
// DEALINGS IN THE FILE.
//

`include "constants.vams"
`include "disciplines.vams"

module DIODE(a,c);

 parameter real is=1m from (0:inf);	// saturation current (A)
    parameter real tf=0 from [0:inf);	// forward transit time (s)
    parameter real cjo=0 from [0:inf);	// zero-bias junction capacitance (F)
    parameter real phi=0.001 exclude 0;	// built-in junction potential (V)
    inout a, c;
    electrical a, c;
    branch (a, c) res, cap;
    real qd;

    analog begin
	I(res) <+ is*(limexp(V(res)/$vt) - 1);
	qd = tf*I(res) - 2*cjo*phi*sqrt(1 - V(cap)/phi);
	I(cap) <+ ddt(qd);

    $bound_step(0.1/2450e6);
    end

endmodule
